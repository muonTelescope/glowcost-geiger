gLowCost-geiger 3.3V enabled HV feasibility model
* Parameter overrides are generated by scripts/simulate_hv.py.
.param VBAT=3.3 LVAL=1m DCR=9.5 CW=10n FREQ=10000 TON=20u ILOAD=1u
Vbat battery 0 {VBAT}
Rbat battery vin 0.5
Cin vin 0 22u ic=0
Rcoil vin coil {DCR}
L1 coil sw {LVAL} ic=0
Smain sw 0 gate 0 POWER
Coss sw 0 30p
Dbody 0 sw DFAST
.model POWER SW(Ron=2 Roff=1e10 Vt=0.5 Vh=0)
.model DFAST D(Is=2n N=1.7 Rs=2 Cjo=2p Tt=50n Bv=250 Ibv=1u)
* Four CW stages, one stage = two diodes and two capacitors.
C1 sw p1 {CW} ic=0
D1 0 p1 DFAST
D2 p1 s1 DFAST
C2 s1 0 {CW} ic=0
C3 p1 p2 {CW} ic=0
D3 s1 p2 DFAST
D4 p2 s2 DFAST
C4 s2 s1 {CW} ic=0
C5 p2 p3 {CW} ic=0
D5 s2 p3 DFAST
D6 p3 s3 DFAST
C6 s3 s2 {CW} ic=0
C7 p3 p4 {CW} ic=0
D7 s3 p4 DFAST
D8 p4 hv DFAST
C8 hv s3 {CW} ic=0
* Separate always-connected monitor divider; comparator senses it ideally.
Rtop1 hv div1 33Meg
Rtop2 div1 div2 33Meg
Rtop3 div2 div3 33Meg
Rtop4 div3 sense 33Meg
Rbottom sense 0 412k
Csense sense 0 100p ic=0
* Soft load turn-on prevents nonphysical negative output at t=0.
Bload hv 0 I={ILOAD*max(0,min(1,v(hv)/100))}
* Behavioral comparator: 1.242 V reference, 8 mV total input hysteresis.
* 40 us output time constant is a conservative behavioral assumption.
Vlogic logic 0 1
Rpull logic enable 10k
Sinhibit enable 0 sense 0 HYST OFF
.model HYST SW(Ron=1 Roff=1e12 Vt=1.242 Vh=0.004)
Rdelay enable delayed 10k
Cdelay delayed 0 4n ic=1
Vclock clock 0 PULSE(0 1 0 50n 50n {TON} {1/FREQ})
Bgate gate 0 V={v(clock)*(v(delayed)>0.5)*(v(en)>2)*(v(ovp)<1.242)}
.options method=gear reltol=0.001 abstol=1p vntol=1u
* External active-high enable. Pulldown belongs to module; stimulus is testbench.
Ven en 0 PULSE(0 3.3 5m 1u 1u 195m 500m)
Ren en 0 100k
* Tube load resistor: split to distribute voltage; CTC-5 remains a measured-device TBD.
Ra1 hv amid 2.49Meg
Ra2 amid anode 2.49Meg
Ctube anode cathode 5p
Rk cathode 0 100k
* Synthetic event is enabled only with HV present; no claimed tube model.
Vevent event 0 PULSE(0 1 100m 1u 1u 100u 20m)
Bevent anode cathode I={20u*v(event)*max(0,min(1,v(hv)/360))}
Rprotect cathode base 100k
Qpulse collector base 0 QLOW
.model QLOW NPN(Is=6.7f Bf=100 Vaf=74 Cje=4p Cjc=4p Tf=300p Tr=50n)
Dnegative 0 base DLOW
.model DLOW D(Is=1n N=1 Rs=2 Cjo=2p)
Rcollector vin collector 47k
* Separate HV divider/reference channel: nominal 409.02 V shutdown.
Rovp1 hv ov1 33Meg
Rovp2 ov1 ov2 33Meg
Rovp3 ov2 ov3 33Meg
Rovp4 ov3 ovp 33Meg
Rovpbot ovp 0 402k
Covp ovp 0 10p
* Passive bleeder remains effective without logic power.
Rbleed1 hv bl1 10Meg
Rbleed2 bl1 bl2 10Meg
Rbleed3 bl2 bl3 10Meg
Rbleed4 bl3 0 10Meg
* Output conditioning/blanking behavior; physical logic still needs implementation.
Bttl drive 0 V={v(vin)*(v(collector)<0.8)*(v(en)>2)*(v(hv)>360)*(v(ovp)<1.242)}
Rout drive ttl 1k
Cout ttl 0 50p
Rreceiver ttl 0 100k
.control
set wr_singlescale
set wr_vecnames
tran 10u 0.3 0 2u uic
wrdata metrics.txt v(hv) v(sw) i(L1) i(Vbat) v(en) v(ttl) v(cathode) v(anode) v(gate) v(ovp) v(base) v(collector)
linearize v(hv) v(sw) i(L1) i(Vbat) v(en) v(ttl) v(cathode) v(anode) v(gate) v(ovp) v(base) v(collector)
wrdata wave.txt v(hv) v(sw) i(L1) i(Vbat) v(en) v(ttl) v(cathode) v(anode) v(gate) v(ovp) v(base) v(collector)
quit
.endc
.end
